** sch_path: /home/student/xschem_sky130/eng331lab_xschem/or2.sch
**.subckt or2 A Y B
*.ipin A
*.ipin B
*.opin Y
x1 A B Y_bar nor2
x2 Y Y_bar inv
**.ends

* expanding   symbol:  eng331lab_xschem/nor2.sym # of pins=3
** sym_path: /home/student/xschem_sky130/eng331lab_xschem/nor2.sym
** sch_path: /home/student/xschem_sky130/eng331lab_xschem/nor2.sch
.subckt nor2 A B Y
*.ipin A
*.ipin B
*.opin Y
XM1 net1 A VDD VDD sky130_fd_pr__pfet_01v8 L=0.15 W=1.6 nf=1 ad=0.464 as=0.464 pd=3.78 ps=3.78 nrd=0.18125 nrs=0.18125 sa=0 sb=0
+ sd=0 mult=1 m=1
XM2 Y B net1 VDD sky130_fd_pr__pfet_01v8 L=0.15 W=1.6 nf=1 ad=0.464 as=0.464 pd=3.78 ps=3.78 nrd=0.18125 nrs=0.18125 sa=0 sb=0
+ sd=0 mult=1 m=1
XM3 Y A GND GND sky130_fd_pr__nfet_01v8 L=0.15 W=0.5 nf=1 ad=0.145 as=0.145 pd=1.58 ps=1.58 nrd=0.58 nrs=0.58 sa=0 sb=0 sd=0
+ mult=1 m=1
XM4 Y B GND GND sky130_fd_pr__nfet_01v8 L=0.15 W=0.5 nf=1 ad=0.145 as=0.145 pd=1.58 ps=1.58 nrd=0.58 nrs=0.58 sa=0 sb=0 sd=0
+ mult=1 m=1
.ends

* expanding   symbol:  eng331lab_xschem/inv.sym # of pins=2
** sym_path: /home/student/xschem_sky130/eng331lab_xschem/inv.sym
** sch_path: /home/student/xschem_sky130/eng331lab_xschem/inv.sch
.subckt inv Y A
*.ipin A
*.opin Y
XM1 Y A VDD VDD sky130_fd_pr__pfet_01v8 L=0.15 W=0.8 nf=1 ad=0.232 as=0.232 pd=2.18 ps=2.18 nrd=0.3625 nrs=0.3625 sa=0 sb=0 sd=0
+ mult=1 m=1
XM2 Y A GND GND sky130_fd_pr__nfet_01v8 L=0.15 W=0.5 nf=1 ad=0.145 as=0.145 pd=1.58 ps=1.58 nrd=0.58 nrs=0.58 sa=0 sb=0 sd=0
+ mult=1 m=1
.ends

.GLOBAL VDD
.GLOBAL GND
.end
